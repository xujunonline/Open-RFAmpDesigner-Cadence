// orfadc.repro Spectre macromodel netlist (auto-generated; not a PDK netlist)
simulator lang=spectre
global 0
opts options temp=16.85 tnom=16.85
PORT1 (in 0) port r=50 num=1 mag=1
Lxl1 (in xl1) inductor l=4.43575964141e-10
Rxl1 (xl1 0) resistor r=3.34448397661
Lxl2 (in xl2) inductor l=8.72891805416e-11
Rxl2 (xl2 g1) resistor r=0.658144915986
RG1 (g1 g1i) resistor r=1.11111111111
Gm3 (cas s1 g1i s1) vccs gm=0.088569434656
Rm3ds (cas s1) resistor r=223.377432929 isnoisy=no
Cm3gs (g1i s1) capacitor c=8.505e-14
Cm3gd (g1i cas) capacitor c=3.078e-14
Cm3db (cas 0) capacitor c=4.455e-14
Vwn4 (wn4 0) vsource dc=0
Rwn4 (wn4 0) resistor r=8.21132854802
Fm3d (cas s1) cccs probe=Vwn4 gain=1
Hdx5 (dx5 0) ccvs probe=Vwn4 rm=1
Cdx5 (dx5 dy6) capacitor c=1.9191438281e-13
Vdy6 (dy6 0) vsource dc=0
Fm3gc (g1i s1) cccs probe=Vdy6 gain=1
Vwn7 (wn7 0) vsource dc=0
Rwn7 (wn7 0) resistor r=1
Hdx8 (dx8 0) ccvs probe=Vwn7 rm=1
Cdx8 (dx8 dy9) capacitor c=1.55764506879e-13
Vdy9 (dy9 0) vsource dc=0
Fm3gu (g1i s1) cccs probe=Vdy9 gain=1
Lxl10 (s1 xl10) inductor l=8.20693758304e-11
Rxl10 (xl10 0) resistor r=0.618788515665
GCG (d1 cas 0 cas) vccs gm=0.0560663067355
RCGds (d1 cas) resistor r=223.37790197 isnoisy=no
CCGgs (cas 0) capacitor c=3.82725e-14
CCGdb (d1 0) capacitor c=3.38985e-14
Vwn11 (wn11 0) vsource dc=0
Rwn11 (wn11 0) resistor r=12.9716539151
FCG (d1 cas) cccs probe=Vwn11 gain=1
Lk12p (d1 k12p) inductor l=3.0783039686e-10
Rk12p (k12p 0) resistor r=3.86831085331
Lk12s (g2 k12s) inductor l=9.45954329806e-10
Rk12s (k12s 0) resistor r=11.8872126926
Kk12 mutual_inductor coupling=0.540306580842 ind1=Lk12p ind2=Lk12s
Rk12d1 (d1 0) resistor r=435.730628448
Ck12d1 (d1 0) capacitor c=2.8058085913e-14
Rk12g2 (g2 0) resistor r=910.684955131
Ck12g2 (g2 0) capacitor c=3.35518782389e-14
RG2 (g2 g2i) resistor r=1.66666666667
Gm13 (d2 0 g2i 0) vccs gm=0.0233292691517
Rm13ds (d2 0) resistor r=1521.45205293 isnoisy=no
Cm13gs (g2i 0) capacitor c=5.67e-14
Cm13gd (g2i d2) capacitor c=2.4624e-15
Cm13db (d2 0) capacitor c=2.97e-14
Vwn14 (wn14 0) vsource dc=0
Rwn14 (wn14 0) resistor r=31.1742610771
Fm13d (d2 0) cccs probe=Vwn14 gain=1
Hdx15 (dx15 0) ccvs probe=Vwn14 rm=1
Cdx15 (dx15 dy16) capacitor c=4.85734558801e-13
Vdy16 (dy16 0) vsource dc=0
Fm13gc (g2i 0) cccs probe=Vdy16 gain=1
Vwn17 (wn17 0) vsource dc=0
Rwn17 (wn17 0) resistor r=1
Hdx18 (dx18 0) ccvs probe=Vwn17 rm=1
Cdx18 (dx18 dy19) capacitor c=2.02333882427e-13
Vdy19 (dy19 0) vsource dc=0
Fm13gu (g2i 0) cccs probe=Vdy19 gain=1
Lk20p (d2 k20p) inductor l=1.80333475899e-10
Rk20p (k20p 0) resistor r=2.18375733062
Lk20s (g3 k20s) inductor l=1.80333475899e-10
Rk20s (k20s 0) resistor r=2.18375733062
Kk20 mutual_inductor coupling=0.39366149957 ind1=Lk20p ind2=Lk20s
Rk20d2 (d2 0) resistor r=187.183195508
Ck20d2 (d2 0) capacitor c=1.35161956262e-13
Rk20g3 (g3 0) resistor r=166.677034984
Ck20g3 (g3 0) capacitor c=9.8301556262e-14
RG3 (g3 g3i) resistor r=1.42857142857
Gm21 (d3 0 g3i 0) vccs gm=0.0688873380658
Rm21ds (d3 0) resistor r=287.199556623 isnoisy=no
Cm21gs (g3i 0) capacitor c=6.615e-14
Cm21gd (g3i d3) capacitor c=2.8728e-15
Cm21db (d3 0) capacitor c=3.465e-14
Vwn22 (wn22 0) vsource dc=0
Rwn22 (wn22 0) resistor r=10.5574224189
Fm21d (d3 0) cccs probe=Vwn22 gain=1
Hdx23 (dx23 0) ccvs probe=Vwn22 rm=1
Cdx23 (dx23 dy24) capacitor c=1.9191438281e-13
Vdy24 (dy24 0) vsource dc=0
Fm21gc (g3i 0) cccs probe=Vdy24 gain=1
Vwn25 (wn25 0) vsource dc=0
Rwn25 (wn25 0) resistor r=1
Hdx26 (dx26 0) ccvs probe=Vwn25 rm=1
Cdx26 (dx26 dy27) capacitor c=1.37371382764e-13
Vdy27 (dy27 0) vsource dc=0
Fm21gu (g3i 0) cccs probe=Vdy27 gain=1
Lk28p (d3 k28p) inductor l=2.19509450749e-10
Rk28p (k28p 0) resistor r=2.94627683958
Lk28s (out k28s) inductor l=2.19509450749e-10
Rk28s (k28s 0) resistor r=2.94627683958
Kk28 mutual_inductor coupling=0.172062883024 ind1=Lk28p ind2=Lk28s
Ck28d3 (d3 0) capacitor c=7.43688505398e-14
Rk28out (out 0) resistor r=556.983586783
Ck28out (out 0) capacitor c=4.98916505398e-14
PORT2 (out 0) port r=1787 num=2
CLOAD (out 0) capacitor c=6.2e-14
sp1 sp values=[15000000000 16125000000 17250000000 18375000000 19500000000 20625000000 21750000000 22875000000 24000000000 25125000000 26250000000 27000000000 27300000000 27375000000 27600000000 27900000000 28200000000 28500000000 28800000000 29100000000 29400000000 29625000000 29700000000 30000000000 30300000000 30600000000 30750000000 30900000000 31200000000 31500000000 31800000000 31875000000 32100000000 32400000000 32700000000 33000000000 33000000000 34125000000 35250000000 36375000000 37500000000 38625000000 39750000000 40875000000 42000000000 43125000000 44250000000 45375000000 46500000000 47625000000 48750000000 49875000000 51000000000 52125000000 53250000000 54375000000 55500000000 56625000000 57750000000 58875000000 60000000000] ports=[PORT1 PORT2] donoise=yes oprobe=PORT2 iprobe=PORT1 noisedata=twoport
ac1 ac values=[15000000000 16125000000 17250000000 18375000000 19500000000 20625000000 21750000000 22875000000 24000000000 25125000000 26250000000 27000000000 27300000000 27375000000 27600000000 27900000000 28200000000 28500000000 28800000000 29100000000 29400000000 29625000000 29700000000 30000000000 30300000000 30600000000 30750000000 30900000000 31200000000 31500000000 31800000000 31875000000 32100000000 32400000000 32700000000 33000000000 33000000000 34125000000 35250000000 36375000000 37500000000 38625000000 39750000000 40875000000 42000000000 43125000000 44250000000 45375000000 46500000000 47625000000 48750000000 49875000000 51000000000 52125000000 53250000000 54375000000 55500000000 56625000000 57750000000 58875000000 60000000000]
save in g1i s1 d1 g2 g2i d2 g3 g3i d3 out
