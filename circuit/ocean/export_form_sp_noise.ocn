reportPort=outfile("form_sp_export_report.txt" "w")
aelPushSignifDigits(15)
psfDir=getShellEnvVar("ORFADC_FORM_RESULTS_PSF")
unless(psfDir error("Spectre PSF directory is required"))
openResults(psfDir)
fprintf(reportPort "results=%L\n" results())
selectResult('sp)
fprintf(reportPort "sp_outputs=%L\n" outputs())
foreach(signal list("s11" "s21" "s12" "s22")
  wave=getData(signal)
  unless(wave error("missing SP waveform %s" signal))
  ocnPrint(?output strcat(signal "_real.txt") ?numberNotation 'scientific
    ?precision 15 ?width 24 real(wave))
  ocnPrint(?output strcat(signal "_imag.txt") ?numberNotation 'scientific
    ?precision 15 ?width 24 imag(wave))
)
selectResult('sp_noise)
fprintf(reportPort "noise_outputs=%L\n" outputs())
foreach(signal list("NF" "NFmin" "F" "Fmin")
  wave=getData(signal)
  unless(wave error("missing noise waveform %s" signal))
  ocnPrint(?output strcat(signal ".txt") ?numberNotation 'scientific
    ?precision 15 ?width 24 wave)
)
selectResult('dcOp)
fprintf(reportPort "dc_outputs=%L\n" outputs())
fprintf(reportPort "vdd_current=%L\n" getData("VDD:p"))
close(reportPort)
exit()
