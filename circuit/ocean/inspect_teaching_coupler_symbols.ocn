reportPort=outfile("coupler_symbols_report.txt" "w")
contextPath=getShellEnvVar("ORFADC_SCHEMATIC_CONTEXT")
unless(contextPath && isFile(contextPath) error("Schematic context file is required\n"))
loadContext(contextPath)
libObj=ddGetObj("analogLib")
unless(libObj error("analogLib is unavailable\n"))
foreach(cellName list("ind" "mind" "xfmr" "transformer" "mutual_inductor" "port" "nmos4")
  master=dbOpenCellViewByType("analogLib" cellName "symbol" "" "r")
  if(master then
    fprintf(reportPort "cell=%s status=found terminals=%d\n" cellName length(master~>terminals))
    foreach(term master~>terminals
      fprintf(reportPort "terminal=%s direction=%L\n" term~>name term~>direction)
    )
    when(cellName=="xfmr" || cellName=="mind"
      cdfObj=cdfGetBaseCellCDF(ddGetObj("analogLib" cellName))
      if(cdfObj then
        foreach(param cdfObj~>parameters
          fprintf(reportPort "cdf_param=%s default=%L\n" param~>name param~>defValue)
        )
      else
        fprintf(reportPort "cdf_status=missing\n")
      )
    )
    dbClose(master)
  else
    fprintf(reportPort "cell=%s status=missing\n" cellName)
  )
)
close(reportPort)
exit()
