reportPort=outfile("create_teaching_three_stage_report.txt" "w")
contextPath=getShellEnvVar("ORFADC_SCHEMATIC_CONTEXT")
unless(contextPath && isFile(contextPath) error("Schematic context file is required\n"))
loadContext(contextPath)
libName="orfadc_teaching_mos1"
libPath=getShellEnvVar("ORFADC_TEACHING_LIB_DIR")
cellName=getShellEnvVar("ORFADC_TEACHING_CELL")
unless(libPath && cellName error("Teaching library directory and cell name are required\n"))
libObj=ddGetObj(libName)
unless(libObj libObj=ddCreateLib(libName libPath))
unless(libObj error("Teaching design library unavailable\n"))
oldCv=dbOpenCellViewByType(libName cellName "schematic" "" "r")
when(oldCv
  dbClose(oldCv)
  error("Teaching cell already exists; refusing overwrite\n")
)
cv=dbOpenCellViewByType(libName cellName "schematic" "schematic" "w")
unless(cv error("Teaching three-stage schematic creation failed\n"))

mosMaster=dbOpenCellViewByType("analogLib" "nmos4" "symbol" "" "r")
portMaster=dbOpenCellViewByType("analogLib" "port" "symbol" "" "r")
vdcMaster=dbOpenCellViewByType("analogLib" "vdc" "symbol" "" "r")
resMaster=dbOpenCellViewByType("analogLib" "res" "symbol" "" "r")
capMaster=dbOpenCellViewByType("analogLib" "cap" "symbol" "" "r")
indMaster=dbOpenCellViewByType("analogLib" "ind" "symbol" "" "r")
mindMaster=dbOpenCellViewByType("analogLib" "mind" "symbol" "" "r")
gndMaster=dbOpenCellViewByType("analogLib" "gnd" "symbol" "" "r")
unless(mosMaster && portMaster && vdcMaster && resMaster && capMaster && indMaster && mindMaster && gndMaster
  error("Required analogLib symbol unavailable\n")
)

procedure(orfThreeAdd(cv gndMaster stage idx master name props connections)
  let((col row x y inst term pinCenter instCenter dx dy x2 y2 endpoint wireId ground)
    col=idx
    row=0
    while(col>=5
      col=col-5
      row=row+1
    )
    x=stage*25+col*4
    y=16-row*4
    inst=dbCreateInst(cv master name x:y "R0")
    unless(inst error("Three-stage instance creation failed\n"))
    foreach(prop props
      dbCreateProp(inst car(prop) "string" cadr(prop))
    )
    foreach(connection connections
      term=dbFindTermByName(master car(connection))
      unless(term && term~>pins error("Three-stage master terminal missing\n"))
      pinCenter=dbTransformPoint(centerBox(car(term~>pins)~>fig~>bBox) inst~>transform)
      instCenter=centerBox(inst~>bBox)
      dx=xCoord(pinCenter)-xCoord(instCenter)
      dy=yCoord(pinCenter)-yCoord(instCenter)
      if(abs(dx)>abs(dy) then
        x2=if(dx>=0 then xCoord(pinCenter)+0.75 else xCoord(pinCenter)-0.75)
        y2=yCoord(pinCenter)
      else
        x2=xCoord(pinCenter)
        y2=if(dy>=0 then yCoord(pinCenter)+0.75 else yCoord(pinCenter)-0.75)
      )
      endpoint=x2:y2
      wireId=schCreateWire(cv "draw" "full" list(pinCenter endpoint) 0.0625 0.0625 0.0)
      unless(wireId error("Three-stage terminal wire failed\n"))
      if(cadr(connection)=="0" then
        ground=dbCreateInst(cv gndMaster strcat("GND_" name "_" car(connection)) endpoint "R0")
        unless(ground error("Three-stage ground placement failed\n"))
      else
        schCreateWireLabel(cv car(wireId) endpoint cadr(connection) "lowerLeft" "R0" "stick" 0.0625 nil)
      )
    )
    inst
  )
)

orfThreeAdd(cv gndMaster 0 0 vdcMaster "VDD_SRC" list(list("vdc" "1.2")) list(list("PLUS" "vdd") list("MINUS" "0")))
orfThreeAdd(cv gndMaster 0 1 vdcMaster "VB1_SRC" list(list("vdc" "0.65")) list(list("PLUS" "vb1") list("MINUS" "0")))
orfThreeAdd(cv gndMaster 0 2 vdcMaster "VCAS_SRC" list(list("vdc" "1.05")) list(list("PLUS" "vcas") list("MINUS" "0")))
orfThreeAdd(cv gndMaster 0 3 vdcMaster "VB2_SRC" list(list("vdc" "0.65")) list(list("PLUS" "vb2") list("MINUS" "0")))
orfThreeAdd(cv gndMaster 0 4 vdcMaster "VB3_SRC" list(list("vdc" "0.65")) list(list("PLUS" "vb3") list("MINUS" "0")))

orfThreeAdd(cv gndMaster 1 0 portMaster "PORT1" list(list("num" "1") list("r" "50")) list(list("PLUS" "in") list("MINUS" "0")))
orfThreeAdd(cv gndMaster 1 1 capMaster "CIN" list(list("c" "5p")) list(list("PLUS" "in") list("MINUS" "rf_in")))
orfThreeAdd(cv gndMaster 1 2 indMaster "LG" list(list("l" "1n")) list(list("PLUS" "rf_in") list("MINUS" "g1")))
orfThreeAdd(cv gndMaster 1 3 resMaster "RB1" list(list("r" "100k")) list(list("PLUS" "g1") list("MINUS" "vb1")))
orfThreeAdd(cv gndMaster 1 4 mosMaster "M1" list(list("model" "n_teach") list("w" "300u") list("l" "100n")) list(list("D" "cas") list("G" "g1") list("S" "s1") list("B" "0")))
orfThreeAdd(cv gndMaster 1 5 indMaster "LS" list(list("l" "240p")) list(list("PLUS" "s1") list("MINUS" "0")))
orfThreeAdd(cv gndMaster 1 6 mosMaster "M2" list(list("model" "n_teach") list("w" "300u") list("l" "100n")) list(list("D" "d1") list("G" "vcas") list("S" "cas") list("B" "0")))
orfThreeAdd(cv gndMaster 1 7 indMaster "L12P" list(list("l" "1.68809309279457n")) list(list("PLUS" "vdd") list("MINUS" "d1")))
orfThreeAdd(cv gndMaster 1 8 resMaster "R12P" list(list("r" "150")) list(list("PLUS" "vdd") list("MINUS" "d1")))
orfThreeAdd(cv gndMaster 1 9 capMaster "C12P" list(list("c" "225.079079039277f")) list(list("PLUS" "vdd") list("MINUS" "d1")))
orfThreeAdd(cv gndMaster 1 10 indMaster "L12S" list(list("l" "1n")) list(list("PLUS" "g2p") list("MINUS" "g2n")))
orfThreeAdd(cv gndMaster 1 11 mindMaster "K12" list(list("ind1" "L12P") list("ind2" "L12S") list("k" "0.45")) nil)

orfThreeAdd(cv gndMaster 2 0 resMaster "RB2P" list(list("r" "100k")) list(list("PLUS" "g2p") list("MINUS" "vb2")))
orfThreeAdd(cv gndMaster 2 1 resMaster "RB2N" list(list("r" "100k")) list(list("PLUS" "g2n") list("MINUS" "vb2")))
orfThreeAdd(cv gndMaster 2 2 mosMaster "M3" list(list("model" "n_teach") list("w" "200u") list("l" "100n")) list(list("D" "d2p") list("G" "g2p") list("S" "s2p") list("B" "0")))
orfThreeAdd(cv gndMaster 2 3 mosMaster "M4" list(list("model" "n_teach") list("w" "200u") list("l" "100n")) list(list("D" "d2n") list("G" "g2n") list("S" "s2n") list("B" "0")))
orfThreeAdd(cv gndMaster 2 4 resMaster "RS2P" list(list("r" "10")) list(list("PLUS" "s2p") list("MINUS" "0")))
orfThreeAdd(cv gndMaster 2 5 resMaster "RS2N" list(list("r" "10")) list(list("PLUS" "s2n") list("MINUS" "0")))
orfThreeAdd(cv gndMaster 2 6 resMaster "RD2P" list(list("r" "150")) list(list("PLUS" "vdd") list("MINUS" "d2p")))
orfThreeAdd(cv gndMaster 2 7 resMaster "RD2N" list(list("r" "150")) list(list("PLUS" "vdd") list("MINUS" "d2n")))
orfThreeAdd(cv gndMaster 2 8 capMaster "CN2P" list(list("c" "10f")) list(list("PLUS" "d2p") list("MINUS" "g2n")))
orfThreeAdd(cv gndMaster 2 9 capMaster "CN2N" list(list("c" "10f")) list(list("PLUS" "d2n") list("MINUS" "g2p")))
orfThreeAdd(cv gndMaster 2 10 indMaster "L23P" list(list("l" "1n")) list(list("PLUS" "d2p") list("MINUS" "d2n")))
orfThreeAdd(cv gndMaster 2 11 capMaster "C23P" list(list("c" "250f")) list(list("PLUS" "d2p") list("MINUS" "d2n")))
orfThreeAdd(cv gndMaster 2 12 indMaster "L23S" list(list("l" "1n")) list(list("PLUS" "g3p") list("MINUS" "g3n")))
orfThreeAdd(cv gndMaster 2 13 mindMaster "K23" list(list("ind1" "L23P") list("ind2" "L23S") list("k" "0.45")) nil)

orfThreeAdd(cv gndMaster 3 0 resMaster "RB3P" list(list("r" "100k")) list(list("PLUS" "g3p") list("MINUS" "vb3")))
orfThreeAdd(cv gndMaster 3 1 resMaster "RB3N" list(list("r" "100k")) list(list("PLUS" "g3n") list("MINUS" "vb3")))
orfThreeAdd(cv gndMaster 3 2 mosMaster "M5" list(list("model" "n_teach") list("w" "200u") list("l" "100n")) list(list("D" "d3p") list("G" "g3p") list("S" "s3p") list("B" "0")))
orfThreeAdd(cv gndMaster 3 3 mosMaster "M6" list(list("model" "n_teach") list("w" "200u") list("l" "100n")) list(list("D" "d3n") list("G" "g3n") list("S" "s3n") list("B" "0")))
orfThreeAdd(cv gndMaster 3 4 resMaster "RS3P" list(list("r" "10")) list(list("PLUS" "s3p") list("MINUS" "0")))
orfThreeAdd(cv gndMaster 3 5 resMaster "RS3N" list(list("r" "10")) list(list("PLUS" "s3n") list("MINUS" "0")))
orfThreeAdd(cv gndMaster 3 6 resMaster "RD3P" list(list("r" "150")) list(list("PLUS" "vdd") list("MINUS" "d3p")))
orfThreeAdd(cv gndMaster 3 7 resMaster "RD3N" list(list("r" "150")) list(list("PLUS" "vdd") list("MINUS" "d3n")))
orfThreeAdd(cv gndMaster 3 8 capMaster "CN3P" list(list("c" "10f")) list(list("PLUS" "d3p") list("MINUS" "g3n")))
orfThreeAdd(cv gndMaster 3 9 capMaster "CN3N" list(list("c" "10f")) list(list("PLUS" "d3n") list("MINUS" "g3p")))
orfThreeAdd(cv gndMaster 3 10 indMaster "L3P" list(list("l" "1n")) list(list("PLUS" "d3p") list("MINUS" "d3n")))
orfThreeAdd(cv gndMaster 3 11 capMaster "C3P" list(list("c" "250f")) list(list("PLUS" "d3p") list("MINUS" "d3n")))
orfThreeAdd(cv gndMaster 3 12 indMaster "L3S" list(list("l" "1n")) list(list("PLUS" "outp") list("MINUS" "outn")))
orfThreeAdd(cv gndMaster 3 13 mindMaster "K3" list(list("ind1" "L3P") list("ind2" "L3S") list("k" "0.45")) nil)
orfThreeAdd(cv gndMaster 3 14 portMaster "PORT2" list(list("num" "2") list("r" "1787")) list(list("PLUS" "outp") list("MINUS" "outn")))
orfThreeAdd(cv gndMaster 3 15 capMaster "CL" list(list("c" "62f")) list(list("PLUS" "outp") list("MINUS" "outn")))

checkResult=schCheck(cv)
fprintf(reportPort "check_return=%L\n" checkResult)
saveResult=dbSave(cv)
fprintf(reportPort "save_return=%L instances=%d nets=%d\n"
  saveResult length(cv~>instances) length(cv~>nets))
foreach(netId cv~>nets
  fprintf(reportPort "net=%s instterms=%d\n" netId~>name length(netId~>instTerms))
)
dbClose(cv)
foreach(master list(mosMaster portMaster vdcMaster resMaster capMaster indMaster mindMaster gndMaster)
  dbClose(master)
)
close(reportPort)
exit()
