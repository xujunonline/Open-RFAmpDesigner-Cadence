reportPath=getShellEnvVar("ORFADC_REPORT")
libName=getShellEnvVar("ORFADC_USER_LIB")
libPath=getShellEnvVar("ORFADC_USER_LIB_PATH")
cellName=getShellEnvVar("ORFADC_USER_CELL")
unless(reportPath && libName && libPath && cellName
  error("netlist context is incomplete"))
reportPort=outfile(reportPath "w")
libObj=ddGetObj(libName)
unless(libObj libObj=ddCreateLib(libName libPath))
unless(libObj error("user library is unavailable"))
simulator('spectre)
design(libName cellName "schematic")
netlistResult=createNetlist(?recreateAll t)
fprintf(reportPort "netlist_result=%L\n" netlistResult)
close(reportPort)
exit()
