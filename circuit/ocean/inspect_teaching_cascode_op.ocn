psfDir=getShellEnvVar("ORFADC_TEACHING_RESULTS_PSF")
unless(psfDir error("Teaching PSF directory is required\n"))
reportPort=outfile("teaching_cascode_op_probe.txt" "w")
openResults(psfDir)
selectResult('dcOpInfo)
fprintf(reportPort "results=%L\n" results())
fprintf(reportPort "outputs=%L\n" outputs())
foreach(instance list("M1" "M2")
  foreach(param list("id" "vgs" "vds" "vdsat" "gm" "gds" "cgs" "cgd")
    key=strcat(instance ":" param)
    value=getData(key)
    unless(numberp(value) error("Missing numeric operating point %s\n" key))
    fprintf(reportPort "%s=%.15g\n" key value)
  )
)
close(reportPort)
exit()
