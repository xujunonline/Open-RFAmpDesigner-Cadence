reportPath=getShellEnvVar("ORFADC_REPORT")
libName=getShellEnvVar("ORFADC_USER_LIB")
libPath=getShellEnvVar("ORFADC_USER_LIB_PATH")
cellName=getShellEnvVar("ORFADC_USER_CELL")
mosName=getShellEnvVar("ORFADC_USER_MOS")
unless(reportPath && libName && libPath && cellName && mosName
  error("readback environment is incomplete"))
reportPort=outfile(reportPath "w")
libObj=ddGetObj(libName)
unless(libObj libObj=ddCreateLib(libName libPath))
unless(libObj error("user library is unavailable"))
cv=dbOpenCellViewByType(libName cellName "schematic" "schematic" "r")
unless(cv error("saved form diagnostic cell is unavailable"))
mos=dbFindAnyInstByName(cv mosName)
unless(mos error("saved MOS instance is unavailable"))
fprintf(reportPort "readback_open=t\n")
foreach(prop mos~>prop
  when(member(prop~>name list("Wfg" "w" "l" "nf" "fingers"))
    fprintf(reportPort "instance name=%s type=%L value=%L\n"
      prop~>name prop~>valueType prop~>value)
  )
)
cdfData=cdfGetInstCDF(mos)
unless(cdfData error("saved instance CDF is unavailable"))
foreach(param cdfData~>parameters
  when(member(param~>name list("Wfg" "w" "l" "nf" "fingers"))
    fprintf(reportPort "cdf name=%s value=%L\n" param~>name param~>value)
  )
)
dbClose(cv)
fprintf(reportPort "readback_complete=t\n")
close(reportPort)
exit()
