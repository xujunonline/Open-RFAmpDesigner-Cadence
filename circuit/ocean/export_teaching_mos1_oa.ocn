reportPort=outfile("teaching_flat_tb_export_report.txt" "w")
aelPushSignifDigits(15)
psfDir=getShellEnvVar("ORFADC_TEACHING_RESULTS_PSF")
unless(psfDir error("Teaching PSF directory is required\n"))
openResults(psfDir)
fprintf(reportPort "results=%L\n" results())
selectResult('sp)
fprintf(reportPort "sp_outputs=%L\n" outputs())
foreach(signal list("s11" "s21" "s12" "s22")
  wave=getData(signal)
  unless(wave error("Missing SP waveform %s\n" signal))
  ocnPrint(?output strcat(signal "_real.txt") ?numberNotation 'scientific
    ?precision 15 ?width 24 real(wave))
  ocnPrint(?output strcat(signal "_imag.txt") ?numberNotation 'scientific
    ?precision 15 ?width 24 imag(wave))
)
selectResult('sp_noise)
fprintf(reportPort "noise_outputs=%L\n" outputs())
foreach(signal list("NF" "NFmin" "F" "Fmin")
  wave=getData(signal)
  unless(wave error("Missing noise waveform %s\n" signal))
  ocnPrint(?output strcat(signal ".txt") ?numberNotation 'scientific
    ?precision 15 ?width 24 wave)
)
selectResult('dcOp)
fprintf(reportPort "dc_outputs=%L\n" outputs())
fprintf(reportPort "vdd_current=%L\n" getData("VDD:p"))
when(getShellEnvVar("ORFADC_TEACHING_CASCODE")=="1"
  selectResult('dcOpInfo)
  opPort=outfile("device_op.txt" "w")
  fprintf(opPort "source_result=%s\n" psfDir)
  foreach(instance list("M1" "M2")
    foreach(param list("id" "vgs" "vds" "vdsat" "gm" "gds" "cgs" "cgd")
      key=strcat(instance ":" param)
      value=getData(key)
      unless(numberp(value) error("Missing numeric operating point %s\n" key))
      fprintf(opPort "%s=%.15g\n" key value)
    )
  )
  close(opPort)
)
close(reportPort)
exit()
