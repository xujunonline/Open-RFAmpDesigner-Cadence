reportPort=outfile("create_teaching_flat_tb_report.txt" "w")
contextPath=getShellEnvVar("ORFADC_SCHEMATIC_CONTEXT")
unless(contextPath && isFile(contextPath) error("Schematic context file is required\n"))
loadContext(contextPath)
libName="orfadc_teaching_mos1"
libPath=getShellEnvVar("ORFADC_TEACHING_LIB_DIR")
cellName=getShellEnvVar("ORFADC_TEACHING_CELL")
unless(libPath && cellName error("Teaching library directory and cell name are required\n"))
libObj=ddGetObj(libName)
unless(libObj libObj=ddCreateLib(libName libPath))
unless(libObj error("Teaching design library unavailable\n"))
oldCv=dbOpenCellViewByType(libName cellName "schematic" "" "r")
when(oldCv
  dbClose(oldCv)
  error("Teaching cell already exists; refusing overwrite\n")
)
cv=dbOpenCellViewByType(libName cellName "schematic" "schematic" "w")
unless(cv error("Teaching testbench creation failed\n"))

mosMaster=dbOpenCellViewByType("analogLib" "nmos4" "symbol" "" "r")
portMaster=dbOpenCellViewByType("analogLib" "port" "symbol" "" "r")
vdcMaster=dbOpenCellViewByType("analogLib" "vdc" "symbol" "" "r")
resMaster=dbOpenCellViewByType("analogLib" "res" "symbol" "" "r")
capMaster=dbOpenCellViewByType("analogLib" "cap" "symbol" "" "r")
gndMaster=dbOpenCellViewByType("analogLib" "gnd" "symbol" "" "r")
unless(mosMaster && portMaster && vdcMaster && resMaster && capMaster && gndMaster
  error("Required analogLib symbol unavailable\n")
)

mos=dbCreateInst(cv mosMaster "M1" 0:0 "R0")
dbCreateProp(mos "model" "string" "n_teach")
dbCreateProp(mos "w" "string" "300u")
dbCreateProp(mos "l" "string" "100n")

p1=dbCreateInst(cv portMaster "PORT1" -3:0 "R0")
dbCreateProp(p1 "num" "string" "1")
dbCreateProp(p1 "r" "string" "50")
p2=dbCreateInst(cv portMaster "PORT2" 3.5:0.5 "R0")
dbCreateProp(p2 "num" "string" "2")
dbCreateProp(p2 "r" "string" "50")

vdd=dbCreateInst(cv vdcMaster "VDD" 1:2.5 "R180")
dbCreateProp(vdd "vdc" "string" "1.2")
vbias=dbCreateInst(cv vdcMaster "VBIAS" -0.5:-2 "R0")
dbCreateProp(vbias "vdc" "string" "0.55")

rd=dbCreateInst(cv resMaster "RD" 1:1.5 "R0")
dbCreateProp(rd "r" "string" "100")
rbias=dbCreateInst(cv resMaster "RBIAS" -0.5:-1 "R0")
dbCreateProp(rbias "r" "string" "1Meg")
cin=dbCreateInst(cv capMaster "CIN" -1.5:0 "R90")
dbCreateProp(cin "c" "string" "10p")
cout=dbCreateInst(cv capMaster "COUT" 2:0.5 "R90")
dbCreateProp(cout "c" "string" "10p")

dbCreateInst(cv gndMaster "GND_MOS" 0.75:-1 "R0")
dbCreateInst(cv gndMaster "GND_P1" -3:-1 "R0")
dbCreateInst(cv gndMaster "GND_P2" 3.5:-1 "R0")
dbCreateInst(cv gndMaster "GND_VDD" 1:3.5 "R0")
dbCreateInst(cv gndMaster "GND_VBIAS" -0.5:-3 "R0")

schCreateWire(cv "draw" "full" list(-3:0 -1.5:0) 0.0625 0.0625 0.0)
schCreateWire(cv "draw" "full" list(-1.125:0 0:0) 0.0625 0.0625 0.0)
schCreateWire(cv "draw" "full" list(-0.5:-1 -0.5:0) 0.0625 0.0625 0.0)
schCreateWire(cv "draw" "full" list(-0.5:-1.375 -0.5:-2) 0.0625 0.0625 0.0)
schCreateWire(cv "draw" "full" list(-0.5:-2.375 -0.5:-3) 0.0625 0.0625 0.0)
schCreateWire(cv "draw" "full" list(0.25:0.1875 0.25:0.5 1:0.5 1:1.125) 0.0625 0.0625 0.0)
schCreateWire(cv "draw" "full" list(1:0.5 2:0.5) 0.0625 0.0625 0.0)
schCreateWire(cv "draw" "full" list(2.375:0.5 3.5:0.5) 0.0625 0.0625 0.0)
schCreateWire(cv "draw" "full" list(1:1.5 1:2.5) 0.0625 0.0625 0.0)
schCreateWire(cv "draw" "full" list(1:2.875 1:3.5) 0.0625 0.0625 0.0)
schCreateWire(cv "draw" "full" list(0.25:0 0.75:0 0.75:-1) 0.0625 0.0625 0.0)
schCreateWire(cv "draw" "full" list(0.25:-0.1875 0.25:-0.625 0.75:-0.625) 0.0625 0.0625 0.0)
schCreateWire(cv "draw" "full" list(-3:-0.5 -3:-1) 0.0625 0.0625 0.0)
schCreateWire(cv "draw" "full" list(3.5:0 3.5:-1) 0.0625 0.0625 0.0)

checkResult=schCheck(cv)
fprintf(reportPort "check_return=%L\n" checkResult)
saveResult=dbSave(cv)
fprintf(reportPort "save_return=%L instances=%d nets=%d\n"
  saveResult length(cv~>instances) length(cv~>nets))
foreach(netId cv~>nets
  fprintf(reportPort "net=%s instterms=%d\n" netId~>name length(netId~>instTerms))
)
dbClose(cv)
foreach(master list(mosMaster portMaster vdcMaster resMaster capMaster gndMaster)
  dbClose(master)
)
close(reportPort)
exit()
