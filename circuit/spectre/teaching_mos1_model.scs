// Invented pedagogic MOS1 model, not a foundry model or PDK substitute.
simulator lang=spectre
model n_teach mos1 type=n vto=0.45 kp=80u lambda=0.03 tox=3n \
    gamma=0 capmod=bsim cgso=0 cgdo=0 tnom=27
