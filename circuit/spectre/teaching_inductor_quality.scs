// Public lossy R-L with shunt parasitic C; calibration only, not a PDK inductor.
simulator lang=spectre
global 0

PORT1 (p 0) port r=50 num=1 type=sine
RS (p x) resistor r=2
LS (x 0) inductor l=1n
CP (p 0) capacitor c=100f

saveOptions options save=allpub
sp sp start=500M stop=30G lin=590 ports=[PORT1] \
    paramtype=s file="teaching_inductor_quality.s1p" datafmt=touchstone
