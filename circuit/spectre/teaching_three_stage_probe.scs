// Public MOS1 topology probe, not the paper's PDK, MCR, layout, or qualified LNA.
// PORT1 is 50 ohm; PORT2 is a floating 1787 ohm differential load port.
// S21 therefore uses mixed port references and is not a 50-to-50 gain claim.
simulator lang=spectre
global 0
include "teaching_mos1_model.scs"

parameters VDD=1.2 VBIAS1=0.65 VCAS=1.05 VBIAS2=0.65 VBIAS3=0.65

VDD_SRC (vdd 0) vsource dc=VDD
VB1_SRC (vb1 0) vsource dc=VBIAS1
VCAS_SRC (vcas 0) vsource dc=VCAS
VB2_SRC (vb2 0) vsource dc=VBIAS2
VB3_SRC (vb3 0) vsource dc=VBIAS3

PORT1 (in 0) port r=50 num=1 type=sine
CIN (in rf_in) capacitor c=5p
LG (rf_in g1) inductor l=1n
RB1 (g1 vb1) resistor r=100k
M1 (cas g1 s1 0) n_teach w=300u l=100n
LS (s1 0) inductor l=240p
M2 (d1 vcas cas 0) n_teach w=300u l=100n
L12P (vdd d1) inductor l=1.68809309279457n
R12P (vdd d1) resistor r=150
C12P (vdd d1) capacitor c=225.079079039277f
L12S (g2p g2n) inductor l=1n
K12 mutual_inductor coupling=0.45 ind1=L12P ind2=L12S

RB2P (g2p vb2) resistor r=100k
RB2N (g2n vb2) resistor r=100k
M3 (d2p g2p s2p 0) n_teach w=200u l=100n
M4 (d2n g2n s2n 0) n_teach w=200u l=100n
RS2P (s2p 0) resistor r=10
RS2N (s2n 0) resistor r=10
RD2P (vdd d2p) resistor r=150
RD2N (vdd d2n) resistor r=150
CN2P (d2p g2n) capacitor c=10f
CN2N (d2n g2p) capacitor c=10f
L23P (d2p d2n) inductor l=1n
C23P (d2p d2n) capacitor c=250f
L23S (g3p g3n) inductor l=1n
K23 mutual_inductor coupling=0.45 ind1=L23P ind2=L23S

RB3P (g3p vb3) resistor r=100k
RB3N (g3n vb3) resistor r=100k
M5 (d3p g3p s3p 0) n_teach w=200u l=100n
M6 (d3n g3n s3n 0) n_teach w=200u l=100n
RS3P (s3p 0) resistor r=10
RS3N (s3n 0) resistor r=10
RD3P (vdd d3p) resistor r=150
RD3N (vdd d3n) resistor r=150
CN3P (d3p g3n) capacitor c=10f
CN3N (d3n g3p) capacitor c=10f
L3P (d3p d3n) inductor l=1n
C3P (d3p d3n) capacitor c=250f
L3S (outp outn) inductor l=1n
K3 mutual_inductor coupling=0.45 ind1=L3P ind2=L3S

PORT2 (outp outn) port r=1787 num=2 type=sine
CL (outp outn) capacitor c=62f

saveOptions options save=allpub
dcOp dc
dcOpInfo info what=oppoint where=rawfile
sp sp start=8G stop=12G lin=160 ports=[PORT1 PORT2] \
    paramtype=s file="teaching_three_stage_probe.s2p" datafmt=touchstone \
    donoise=yes oprobe=PORT2 iprobe=PORT1 noisedata=twoport
