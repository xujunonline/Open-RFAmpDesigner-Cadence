reportPort=outfile(getShellEnvVar("ORFADC_REPORT") "w")
libName=getShellEnvVar("ORFADC_USER_LIB")
libPath=getShellEnvVar("ORFADC_USER_LIB_PATH")
cellName=getShellEnvVar("ORFADC_USER_CELL")
mosName=getShellEnvVar("ORFADC_USER_MOS")
libObj=ddGetObj(libName)
unless(libObj libObj=ddCreateLib(libName libPath))
unless(libObj error("user library registration failed"))
cv=dbOpenCellViewByType(libName cellName "schematic" "schematic" "r")
unless(cv error("focus probe source cell is unavailable"))
window=geOpen(?lib libName ?cell cellName ?view "schematic" ?mode "r")
unless(window error("focus probe schematic window did not open"))
mos=dbFindAnyInstByName(geGetWindowCellView() mosName)
unless(mos error("focus probe MOS instance is unavailable"))
geSelectFig(mos)
schHiObjectProperty()
unless(boundp('schObjPropForm) && schObjPropForm && schObjPropForm~>Wfg
  error("focus probe Wfg form field is unavailable"))
fprintf(reportPort "form_present=t\n")
fprintf(reportPort "set_focus_available=%L\n" isCallable('hiSetCurrentField))
fprintf(reportPort "get_focus_available=%L\n" isCallable('hiGetKeyboardFocusField))
fprintf(reportPort "is_displayed_available=%L\n" isCallable('hiIsFormDisplayed))
when(isCallable('hiIsFormDisplayed)
  fprintf(reportPort "form_displayed=%L\n" hiIsFormDisplayed(schObjPropForm))
)
fprintf(reportPort "current_form_present=%L\n" (hiGetCurrentForm()!=nil))
when(isCallable('hiSetCurrentField) && isCallable('hiGetKeyboardFocusField)
  fprintf(reportPort "focus_before=%L\n" hiGetKeyboardFocusField(schObjPropForm))
  fprintf(reportPort "set_focus_return=%L\n" hiSetCurrentField(schObjPropForm 'Wfg))
  fprintf(reportPort "focus_after=%L\n" hiGetKeyboardFocusField(schObjPropForm))
)
procedure(orfadcFocusLater()
  fprintf(reportPort "form_displayed_later=%L\n" hiIsFormDisplayed(schObjPropForm))
  fprintf(reportPort "focus_later_before=%L\n" hiGetKeyboardFocusField(schObjPropForm))
  fprintf(reportPort "set_focus_later_return=%L\n" hiSetCurrentField(schObjPropForm 'Wfg))
  fprintf(reportPort "focus_later_after=%L\n" hiGetKeyboardFocusField(schObjPropForm))
  fprintf(reportPort "form_focus_probe_end=t\n")
  close(reportPort)
  hiFormCancel(schObjPropForm)
  exit()
)
hiRegTimer("orfadcFocusLater()" 600)
